ADE simulation setup
Test TeamKEK_Neuron_1: TeamKEK/Neuron/schematic, simulator hspiceD
